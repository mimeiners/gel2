* RC Hochpass

* ZWEITOR
C1 V2 V1 100n
R1 0 V2 1k
V1 V1 0 AC 1

.control
ac dec 20 1 100k
let phase=180/PI*vp(v2)
wrdata hw4p1.csv vdb(v2) phase
.endc

.end
